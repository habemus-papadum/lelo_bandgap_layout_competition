* Standalone bandgap: generated from the bundled Xschem hierarchy.
* Pure schematic including LELOTEMP_OTAR; external Sky130 models loaded by bench.
** sch_path: schematic/LELO_TEMP_SKY130A/LELOTEMP_BIAS_IBP.sch
.subckt LELOTEMP_BIAS_IBP VDD_1V8 LPI IBP_1U<3> IBP_1U<2> IBP_1U<1> IBP_1U<0> LPO VD1 PWRUP_1V8 VSS PWRUP_N_1V8
*.PININFO VDD_1V8:I VSS:I LPI:I LPO:O IBP_1U[3:0]:O VD1:O PWRUP_1V8:I PWRUP_N_1V8:I
xca2 VBD2 LPI VDD_1V8 VDD_1V8 REYATR_PCH_4C5F0
xca1<7> VBD1 LPI VDD_1V8 VDD_1V8 REYATR_PCH_4C5F0
xca1<6> VBD1 LPI VDD_1V8 VDD_1V8 REYATR_PCH_4C5F0
xca1<5> VBD1 LPI VDD_1V8 VDD_1V8 REYATR_PCH_4C5F0
xca1<4> VBD1 LPI VDD_1V8 VDD_1V8 REYATR_PCH_4C5F0
xca1<3> VBD1 LPI VDD_1V8 VDD_1V8 REYATR_PCH_4C5F0
xca1<2> VBD1 LPI VDD_1V8 VDD_1V8 REYATR_PCH_4C5F0
xca1<1> VBD1 LPI VDD_1V8 VDD_1V8 REYATR_PCH_4C5F0
xca1<0> VBD1 LPI VDD_1V8 VDD_1V8 REYATR_PCH_4C5F0
xd1<9> LPI VDD_1V8 REYATR_CAPX1
xd1<8> LPI VDD_1V8 REYATR_CAPX1
xd1<7> LPI VDD_1V8 REYATR_CAPX1
xd1<6> LPI VDD_1V8 REYATR_CAPX1
xd1<5> LPI VDD_1V8 REYATR_CAPX1
xd1<4> LPI VDD_1V8 REYATR_CAPX1
xd1<3> LPI VDD_1V8 REYATR_CAPX1
xd1<2> LPI VDD_1V8 REYATR_CAPX1
xd1<1> LPI VDD_1V8 REYATR_CAPX1
xd1<0> LPI VDD_1V8 REYATR_CAPX1
xad6 VDD_1V8 VR1 LPO VD1 VSS PWRUP_1V8 PWRUP_N_1V8 VCP LELOTEMP_OTAR
xca3<3> IBD<3> LPI VDD_1V8 VDD_1V8 REYATR_PCH_4C5F0
xca3<2> IBD<2> LPI VDD_1V8 VDD_1V8 REYATR_PCH_4C5F0
xca3<1> IBD<1> LPI VDD_1V8 VDD_1V8 REYATR_PCH_4C5F0
xca3<0> IBD<0> LPI VDD_1V8 VDD_1V8 REYATR_PCH_4C5F0
xe1 VD2 VD1 VSS LELOTEMP_BIPOLAR
xg1 VR1 VR1 VD2 VSS REYATR_NCH_4C5F0
xcc<4> VDD_1V8 VDD_1V8 VDD_1V8 VDD_1V8 REYATR_PCH_4C5F0
xcc<3> VDD_1V8 VDD_1V8 VDD_1V8 VDD_1V8 REYATR_PCH_4C5F0
xcc<2> VDD_1V8 VDD_1V8 VDD_1V8 VDD_1V8 REYATR_PCH_4C5F0
xcc<1> VDD_1V8 VDD_1V8 VDD_1V8 VDD_1V8 REYATR_PCH_4C5F0
xcc<0> VDD_1V8 VDD_1V8 VDD_1V8 VDD_1V8 REYATR_PCH_4C5F0
xca2<3> IBP_1U<3> VCP IBD<3> VDD_1V8 REYATR_PCH_4C1F2
xca2<2> IBP_1U<2> VCP IBD<2> VDD_1V8 REYATR_PCH_4C1F2
xca2<1> IBP_1U<1> VCP IBD<1> VDD_1V8 REYATR_PCH_4C1F2
xca2<0> IBP_1U<0> VCP IBD<0> VDD_1V8 REYATR_PCH_4C1F2
xca4 VR1 VCP VBD2 VDD_1V8 REYATR_PCH_4C1F2
xca5<7> VD1 VCP VBD1 VDD_1V8 REYATR_PCH_4C1F2
xca5<6> VD1 VCP VBD1 VDD_1V8 REYATR_PCH_4C1F2
xca5<5> VD1 VCP VBD1 VDD_1V8 REYATR_PCH_4C1F2
xca5<4> VD1 VCP VBD1 VDD_1V8 REYATR_PCH_4C1F2
xca5<3> VD1 VCP VBD1 VDD_1V8 REYATR_PCH_4C1F2
xca5<2> VD1 VCP VBD1 VDD_1V8 REYATR_PCH_4C1F2
xca5<1> VD1 VCP VBD1 VDD_1V8 REYATR_PCH_4C1F2
xca5<0> VD1 VCP VBD1 VDD_1V8 REYATR_PCH_4C1F2
xd2<2> VCP VDD_1V8 REYATR_CAPX1
xd2<1> VCP VDD_1V8 REYATR_CAPX1
xd2<0> VCP VDD_1V8 REYATR_CAPX1
xsu1 VSU VSU VDD_1V8 VDD_1V8 REYATR_PCH_2C5F0
xsu2 VD1 VD1 VSU VDD_1V8 REYATR_PCH_2C5F0
xd3<5> VR1 R1<4> VSS REYATR_RES_36C2F0
xd3<4> R1<4> R1<3> VSS REYATR_RES_36C2F0
xd3<3> R1<3> R1<2> VSS REYATR_RES_36C2F0
xd3<2> R1<2> R1<1> VSS REYATR_RES_36C2F0
xd3<1> R1<1> R1<0> VSS REYATR_RES_36C2F0
xd3<0> R1<0> VD2 VSS REYATR_RES_36C2F0
xfill_p_su<10> VDD_1V8 VDD_1V8 VDD_1V8 VDD_1V8 REYATR_PCH_2C5F0
xfill_p_su<9> VDD_1V8 VDD_1V8 VDD_1V8 VDD_1V8 REYATR_PCH_2C5F0
xfill_p_su<8> VDD_1V8 VDD_1V8 VDD_1V8 VDD_1V8 REYATR_PCH_2C5F0
xfill_p_su<7> VDD_1V8 VDD_1V8 VDD_1V8 VDD_1V8 REYATR_PCH_2C5F0
xfill_p_su<6> VDD_1V8 VDD_1V8 VDD_1V8 VDD_1V8 REYATR_PCH_2C5F0
xfill_p_su<5> VDD_1V8 VDD_1V8 VDD_1V8 VDD_1V8 REYATR_PCH_2C5F0
xfill_p_su<4> VDD_1V8 VDD_1V8 VDD_1V8 VDD_1V8 REYATR_PCH_2C5F0
xfill_p_su<3> VDD_1V8 VDD_1V8 VDD_1V8 VDD_1V8 REYATR_PCH_2C5F0
xfill_p_su<2> VDD_1V8 VDD_1V8 VDD_1V8 VDD_1V8 REYATR_PCH_2C5F0
xfill_p_su<1> VDD_1V8 VDD_1V8 VDD_1V8 VDD_1V8 REYATR_PCH_2C5F0
xfill_p_su<0> VDD_1V8 VDD_1V8 VDD_1V8 VDD_1V8 REYATR_PCH_2C5F0
xfill_p_cc<7> VDD_1V8 VDD_1V8 VDD_1V8 VDD_1V8 REYATR_PCH_4C5F0
xfill_p_cc<6> VDD_1V8 VDD_1V8 VDD_1V8 VDD_1V8 REYATR_PCH_4C5F0
xfill_p_cc<5> VDD_1V8 VDD_1V8 VDD_1V8 VDD_1V8 REYATR_PCH_4C5F0
xfill_p_cc<4> VDD_1V8 VDD_1V8 VDD_1V8 VDD_1V8 REYATR_PCH_4C5F0
xfill_p_cc<3> VDD_1V8 VDD_1V8 VDD_1V8 VDD_1V8 REYATR_PCH_4C5F0
xfill_p_cc<2> VDD_1V8 VDD_1V8 VDD_1V8 VDD_1V8 REYATR_PCH_4C5F0
xfill_p_cc<1> VDD_1V8 VDD_1V8 VDD_1V8 VDD_1V8 REYATR_PCH_4C5F0
xfill_p_cc<0> VDD_1V8 VDD_1V8 VDD_1V8 VDD_1V8 REYATR_PCH_4C5F0
.ends

* expanding   symbol:  REY_ATR_SKY130A/REYATR_PCH_4C5F0.sym # of pins=4
** sym_path: cells/REY_ATR_SKY130A/REYATR_PCH_4C5F0.sym
** sch_path: cells/REY_ATR_SKY130A/REYATR_PCH_4C5F0.sch
.subckt REYATR_PCH_4C5F0 D G S B
*.PININFO D:B G:B S:B B:B
XM1 D G S B sky130_fd_pr__pfet_01v8 L=0.94 W=3.2 nf=2 m=1
.ends

* expanding   symbol:  REY_ATR_SKY130A/REYATR_CAPX1.sym # of pins=2
** sym_path: cells/REY_ATR_SKY130A/REYATR_CAPX1.sym
** sch_path: cells/REY_ATR_SKY130A/REYATR_CAPX1.sch
.subckt REYATR_CAPX1 A B
*.PININFO A:B B:B
XC1 B A sky130_fd_pr__cap_mim_m3_1 W=4.8 L=5 m=1
.ends

* expanding   symbol:  LELO_TEMP_SKY130A/LELOTEMP_OTAR.sym # of pins=8
** sym_path: schematic/LELO_TEMP_SKY130A/LELOTEMP_OTAR.sym
** sch_path: schematic/LELO_TEMP_SKY130A/LELOTEMP_OTAR.sch
.subckt LELOTEMP_OTAR VDD_1V8 VIP VO VIN VSS PWRUP_1V8 PWRUP_N_1V8 VCP
*.PININFO VO:O VIP:I VIN:I VDD_1V8:I VSS:I PWRUP_N_1V8:I PWRUP_1V8:I VCP:O
xnd1<3> VD1 VD1 VSS VSS REYATR_NCH_4C5F0
xnd1<2> VD1 VD1 VSS VSS REYATR_NCH_4C5F0
xnd1<1> VD1 VD1 VSS VSS REYATR_NCH_4C5F0
xnd1<0> VD1 VD1 VSS VSS REYATR_NCH_4C5F0
xnd2<3> VD2 VD2 VSS VSS REYATR_NCH_4C5F0
xnd2<2> VD2 VD2 VSS VSS REYATR_NCH_4C5F0
xnd2<1> VD2 VD2 VSS VSS REYATR_NCH_4C5F0
xnd2<0> VD2 VD2 VSS VSS REYATR_NCH_4C5F0
xba6 VBP VBP VDD_1V8 VDD_1V8 REYATR_PCH_11C5F0
xnd3 VBP VD1 VSS VSS REYATR_NCH_4C5F0
xba8 VO VBP VDD_1V8 VDD_1V8 REYATR_PCH_11C5F0
xnd4 VO VD2 VSS VSS REYATR_NCH_4C5F0
xd2<1> VDS R1<0> VSS REYATR_RES_36C2F0
xd2<0> R1<0> VS VSS REYATR_RES_36C2F0
xba7 VBP PWRUP_1V8 VDD_1V8 VDD_1V8 REYATR_PCH_11C5F0
xba1 VDS PWRUP_N_1V8 VDD_1V8 VDD_1V8 REYATR_PCH_11C5F0
xba2 VO PWRUP_1V8 VDD_1V8 VDD_1V8 REYATR_PCH_11C5F0
xns1 VD1 PWRUP_N_1V8 VSS VSS REYATR_NCH_4C5F0
xns2 VD2 PWRUP_N_1V8 VSS VSS REYATR_NCH_4C5F0
xnc0 VD3 VD3 VSS VSS REYATR_NCH_4C5F0
xnc1<2> VCP VD3 VSS VSS REYATR_NCH_4C5F0
xnc1<1> VCP VD3 VSS VSS REYATR_NCH_4C5F0
xnc1<0> VCP VD3 VSS VSS REYATR_NCH_4C5F0
xbs6 net1 VCP VDD_1V8 VDD_1V8 REYATR_PCH_4C1F2
xbs1 net2 VCP net1 VDD_1V8 REYATR_PCH_4C1F2
xbs2 net4 VCP net2 VDD_1V8 REYATR_PCH_4C1F2
xbs4 net3 VCP net4 VDD_1V8 REYATR_PCH_4C1F2
xbs7 net5 VCP net3 VDD_1V8 REYATR_PCH_4C1F2
xns4 VD3 PWRUP_N_1V8 VSS VSS REYATR_NCH_4C5F0
xba3 VCP PWRUP_1V8 VDD_1V8 VDD_1V8 REYATR_PCH_11C5F0
xbs8 VCP VCP net5 VDD_1V8 REYATR_PCH_4C1F2
xbl1<3> VD1 VIN VS VDD_1V8 REYATR_LVT_PCH_11C5F0
xbl1<2> VD1 VIN VS VDD_1V8 REYATR_LVT_PCH_11C5F0
xbl1<1> VD1 VIN VS VDD_1V8 REYATR_LVT_PCH_11C5F0
xbl1<0> VD1 VIN VS VDD_1V8 REYATR_LVT_PCH_11C5F0
xbl2<3> VD2 VIP VS VDD_1V8 REYATR_LVT_PCH_11C5F0
xbl2<2> VD2 VIP VS VDD_1V8 REYATR_LVT_PCH_11C5F0
xbl2<1> VD2 VIP VS VDD_1V8 REYATR_LVT_PCH_11C5F0
xbl2<0> VD2 VIP VS VDD_1V8 REYATR_LVT_PCH_11C5F0
xbl4 VD3 VIN VS VDD_1V8 REYATR_LVT_PCH_11C5F0
xbl5 VD3 VIP VS VDD_1V8 REYATR_LVT_PCH_11C5F0
xfill_p_in_a_0 VDD_1V8 VDD_1V8 VDD_1V8 VDD_1V8 REYATR_LVT_PCH_11C5F0
xfill_p_in_b_0 VDD_1V8 VDD_1V8 VDD_1V8 VDD_1V8 REYATR_LVT_PCH_11C5F0
xfill_n_mirr_0 VSS VSS VSS VSS REYATR_NCH_4C5F0
.ends

* expanding   symbol:  LELO_TEMP_SKY130A/LELOTEMP_BIPOLAR.sym # of pins=3
** sym_path: schematic/LELO_TEMP_SKY130A/LELOTEMP_BIPOLAR.sym
** sch_path: schematic/LELO_TEMP_SKY130A/LELOTEMP_BIPOLAR.sch
.subckt LELOTEMP_BIPOLAR VD2 VD1 VSS
*.PININFO VSS:I VD1:I VD2:I
XQ1 VSS VSS VD1 sky130_fd_pr__pnp_05v5_W3p40L3p40 m=1
XQ2<7> VSS VSS VD2 sky130_fd_pr__pnp_05v5_W3p40L3p40 m=1
XQ2<6> VSS VSS VD2 sky130_fd_pr__pnp_05v5_W3p40L3p40 m=1
XQ2<5> VSS VSS VD2 sky130_fd_pr__pnp_05v5_W3p40L3p40 m=1
XQ2<4> VSS VSS VD2 sky130_fd_pr__pnp_05v5_W3p40L3p40 m=1
XQ2<3> VSS VSS VD2 sky130_fd_pr__pnp_05v5_W3p40L3p40 m=1
XQ2<2> VSS VSS VD2 sky130_fd_pr__pnp_05v5_W3p40L3p40 m=1
XQ2<1> VSS VSS VD2 sky130_fd_pr__pnp_05v5_W3p40L3p40 m=1
XQ2<0> VSS VSS VD2 sky130_fd_pr__pnp_05v5_W3p40L3p40 m=1
.ends

* expanding   symbol:  REY_ATR_SKY130A/REYATR_NCH_4C5F0.sym # of pins=4
** sym_path: cells/REY_ATR_SKY130A/REYATR_NCH_4C5F0.sym
** sch_path: cells/REY_ATR_SKY130A/REYATR_NCH_4C5F0.sch
.subckt REYATR_NCH_4C5F0 D G S B
*.PININFO D:B G:B S:B B:B
XM1 D G S B sky130_fd_pr__nfet_01v8 L=0.94 W=3.2 nf=2 m=1
.ends

* expanding   symbol:  REY_ATR_SKY130A/REYATR_PCH_4C1F2.sym # of pins=4
** sym_path: cells/REY_ATR_SKY130A/REYATR_PCH_4C1F2.sym
** sch_path: cells/REY_ATR_SKY130A/REYATR_PCH_4C1F2.sch
.subckt REYATR_PCH_4C1F2 D G S B
*.PININFO D:B G:B S:B B:B
XM1 D G S B sky130_fd_pr__pfet_01v8 L=0.22 W=3.2 nf=2 m=1
.ends

* expanding   symbol:  REY_ATR_SKY130A/REYATR_PCH_2C5F0.sym # of pins=4
** sym_path: cells/REY_ATR_SKY130A/REYATR_PCH_2C5F0.sym
** sch_path: cells/REY_ATR_SKY130A/REYATR_PCH_2C5F0.sch
.subckt REYATR_PCH_2C5F0 D G S B
*.PININFO D:B G:B S:B B:B
XM1 D G S B sky130_fd_pr__pfet_01v8 L=0.94 W=1.92 nf=2 m=1
.ends

* expanding   symbol:  REY_ATR_SKY130A/REYATR_RES_36C2F0.sym # of pins=3
** sym_path: cells/REY_ATR_SKY130A/REYATR_RES_36C2F0.sym
** sch_path: cells/REY_ATR_SKY130A/REYATR_RES_36C2F0.sch
.subckt REYATR_RES_36C2F0 N P B
*.PININFO N:B P:B B:B
XR1_0 INT_0 N B sky130_fd_pr__res_high_po W=0.4 L=8.16 mult=1 m=1
XR1_1 P INT_0 B sky130_fd_pr__res_high_po W=0.4 L=8.16 mult=1 m=1
.ends

* expanding   symbol:  REY_ATR_SKY130A/REYATR_PCH_11C5F0.sym # of pins=4
** sym_path: cells/REY_ATR_SKY130A/REYATR_PCH_11C5F0.sym
** sch_path: cells/REY_ATR_SKY130A/REYATR_PCH_11C5F0.sch
.subckt REYATR_PCH_11C5F0 D G S B
*.PININFO D:B G:B S:B B:B
XM1 D G S B sky130_fd_pr__pfet_01v8 L=0.94 W=7.68 nf=2 m=1
.ends

* expanding   symbol:  REY_ATR_SKY130A/REYATR_LVT_PCH_11C5F0.sym # of pins=4
** sym_path: cells/REY_ATR_SKY130A/REYATR_LVT_PCH_11C5F0.sym
** sch_path: cells/REY_ATR_SKY130A/REYATR_LVT_PCH_11C5F0.sch
.subckt REYATR_LVT_PCH_11C5F0 D G S B
*.PININFO D:B G:B S:B B:B
XM1 D G S B sky130_fd_pr__pfet_01v8_lvt L=0.94 W=7.68 nf=2 m=1
.ends
